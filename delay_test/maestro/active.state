ADE simulation setup
Test Ido_Final_delay_test_1: Ido_Final/delay_test/schematic, simulator spectre
  Models: /data/cadence/gpdk/CDK045/gpdk045_v_6_0/gpdk045/../models/spectre/gpdk045.scs[mc]
  Temperature: 27
  Analysis tran: stop=20*VAR("D")
  Signals: /Y<5>, /C<0>
Run mode: Single Run, Sweeps and Corners
Global variables:
  VDD = 1.2
  VAC = VDD
  D = 500n
  Cload = 1f
