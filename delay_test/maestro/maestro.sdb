ADE simulation setup
Run mode: Single Run, Sweeps and Corners
Tests:
  Ido_Final_delay_test_1: Ido_Final/delay_test/schematic, simulator spectre
Global variables:
  VDD = 1.2
  VAC = VDD
  D = 500n
  Cload = 1f
