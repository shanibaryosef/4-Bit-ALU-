ADE simulation setup
Run mode: Single Run, Sweeps and Corners
Tests:
  Ido_Final_test_setup_cq_1: Ido_Final/test_setup_cq/schematic, simulator spectre
Global variables:
  VDD = 0.9
  VAC = VDD
  D = 500n
  delay = -60p
