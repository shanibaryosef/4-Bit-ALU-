ADE simulation setup
Test Ido_Final_test_setup_cq_1: Ido_Final/test_setup_cq/schematic, simulator spectre
  Models: /data/cadence/gpdk/CDK045/gpdk045_v_6_0/gpdk045/../models/spectre/gpdk045.scs[mc]
  Temperature: 27
  Analysis tran: stop=10*VAR("D")
  Signals: /clk, /vin, /Y
Run mode: Single Run, Sweeps and Corners
Global variables:
  VDD = 0.9
  VAC = VDD
  D = 500n
  delay = -60p
