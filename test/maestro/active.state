ADE simulation setup
Test Ido_Final_test_1: Ido_Final/test/schematic, simulator spectre
  Models: /data/cadence/gpdk/CDK045/gpdk045_v_6_0/gpdk045/../models/spectre/gpdk045.scs[mc]
  Temperature: 27
  Analysis tran: stop=20*VAR("D")
  Signals: /Y, /vin
Run mode: Single Run, Sweeps and Corners
Global variables:
  VDD = 1.2
  D = 500n
  VAC = VDD
