ADE simulation setup
Run mode: Single Run, Sweeps and Corners
Tests:
  Ido_Final_test_1: Ido_Final/test/schematic, simulator spectre
Global variables:
  VDD = 1.2
  D = 500n
  VAC = VDD
